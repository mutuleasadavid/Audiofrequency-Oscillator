** Profile: "SCHEMATIC1-bias_point"  [ c:\users\david\onedrive\desktop\tot cef\schematic\circuit-pspicefiles\schematic1\bias_point.sim ]

** Creating circuit file "bias_point.cir"
** WARNING: THIS AUTOMATICALLY GENERATED FILE MAY BE OVERWRITTEN BY SUBSEQUENT SIMULATIONS

*Libraries:
* Profile Libraries :
* Local Libraries :
.LIB "C:/OrCAD/OrCAD_16.6_Lite/tools/capture/library/pspice/SMLS14BET.lib"
.LIB "C:/OrCAD/OrCAD_16.6_Lite/tools/capture/library/pspice/MMBFJ309LT1G.lib"
.LIB "C:/OrCAD/OrCAD_16.6_Lite/tools/capture/library/pspice/BC856B.lib"
.LIB "C:/OrCAD/OrCAD_16.6_Lite/tools/capture/library/pspice/BC846B.lib"
.LIB "C:/OrCAD/OrCAD_16.6_Lite/tools/capture/library/pspice/1N4148.lib"
* From [PSPICE NETLIST] section of C:\Users\David\AppData\Roaming\SPB_Data\cdssetup\OrCAD_PSpice/16.6.0/PSpice.ini file:
.lib "nomd.lib"

*Analysis directives:
.OPTIONS ADVCONV
.PROBE64 V(alias(*)) I(alias(*)) W(alias(*)) D(alias(*)) NOISE(alias(*))
.INC "..\SCHEMATIC1.net"

.END
